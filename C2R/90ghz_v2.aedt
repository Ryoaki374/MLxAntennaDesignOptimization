# Ansys Electronics Desktop project, version 2024.1
materials:
  vacuum: permittivity=1
  pec: conductivity=1e+30

design HFSSDesign1 (HFSS, HFSS Modal Network, model units mm)
variables:
  r_90ghz = (2.97/2) mm
  shell = 1mm
  f0 = 70GHz
  speed_light = 299792458m_per_sec
  WR10x = 2.54mm
  WR10y = WR10x/2
  section_length = speed_light/f0*1.5
  step_y = (r_90ghz*2-WR10y)/5/2
geometry:
  Box1 = box(corner=(-WR10x/2, -WR10y/2, 0mm), size=(WR10x, WR10y, section_length/6))
  Box2 = box(corner=(-WR10x/2, -WR10y/2-step_y, section_length/6), size=(WR10x, WR10y+step_y*2, section_length/6))
  Box3 = box(corner=(-WR10x/2, -WR10y/2-2*step_y, 2*section_length/6), size=(WR10x, WR10y+step_y*4, section_length/6))
  Box4 = box(corner=(-WR10x/2, -WR10y/2-3*step_y, 3*section_length/6), size=(WR10x, WR10y+step_y*6, section_length/6))
  Box5 = box(corner=(-WR10x/2, -WR10y/2-4*step_y, 4*section_length/6), size=(WR10x, WR10y+step_y*8, section_length/6))
  Cylinder3 = cylinder(axis=Z, base_centre=(0mm, 0mm, section_length/6), radius=r_90ghz, height=5*section_length/6)
  Rectangle1 = rectangle(corner=(-WR10x/2, -WR10y/2, 0mm), z_size=section_length/6, x_size=WR10x)
  Cylinder3.split(plane=Rectangle1_1.face, keep=NegativeOnly)
  Rectangle1_1 = Rectangle1.copy()
  Rectangle1_1.delete()
  Rectangle1.split(plane=Rectangle1.face(#384), keep=NegativeOnly)
  Rectangle1.delete()
  Cylinder3.split(plane=Box1_1.face(5 of 6), keep=PositiveOnly)
  Box1_1 = Box1.copy()
  Box1_1.delete()
  Cylinder4 = cylinder(axis=Z, base_centre=(0mm, 0mm, 5*section_length/6), radius=r_90ghz, height=section_length/6)
  Box1.unite(Box2..Box5, Cylinder3, Cylinder4)
  Box6 = box(corner=(-r_90ghz-0.5mm, -r_90ghz-0.5mm, 0mm), size=(r_90ghz*2+1mm, r_90ghz*2+1mm, section_length))
  Box6.subtract(Box1)
  Box7 = box(corner=(-r_90ghz-0.5mm, -r_90ghz-0.5mm, 0mm), size=(r_90ghz*2+1mm, r_90ghz*2+1mm, section_length))
  Box6_1 = Box6.copy()
  Box6.delete()
  Box7.subtract(Box6_1)
  Cylinder5 = cylinder(axis=Z, base_centre=(0mm, 0mm, 0mm), radius=1.485mm, height=section_length)
  Box7.intersect(Cylinder5)
  Cylinder6 [vacuum] = cylinder(axis=Z, base_centre=(0mm, 0mm, section_length/6), radius=1.485mm, height=section_length*4/6)
  Cylinder6.move(0mm, 0mm, 0mm)
  Cylinder6.split(plane=Box7_1.face(15 of 39), keep=PositiveOnly)
  Box7_1 = Box7.copy()
  Box7_1.delete()
  Cylinder6.split(plane=Box7_2.face(13 of 39), keep=PositiveOnly)
  Box7_2 = Box7.copy()
  Box7_2.delete()
  Cylinder6.unite(Box7)
boundaries and excitations:
  C: Wave Port Faces=Cylinder6.face(at (0, 0, 6.42412)) WavePortType=Modal NumModes=5 UseLineModeAlignment Modes{Mode1{IntLine{(0, 0, 6.4241241) -> (0, 1.485, 6.4241241)} CharImp=Zpi} Mode2{IntLine{(0, 0, 6.4241241) -> (-1.485, 0, 6.4241241)} CharImp=Zpi} Mode3{CharImp=Zpi} Mode4{CharImp=Zpi} Mode5{CharImp=Zpi}}
  R: Wave Port Faces=Cylinder6.face(at (0, 0, 0)) WavePortType=Modal NumModes=5 UseLineModeAlignment Modes{Mode1{IntLine{(0, 0, 0) -> (0, 0.635, 0)} CharImp=Zpi} Mode2{IntLine{(0, 0, 0) -> (1.27, 0, 0)} CharImp=Zpi} Mode3{CharImp=Zpi} Mode4{CharImp=Zpi} Mode5{CharImp=Zpi}}
setups:
  Setup1: HfssDriven Frequency=110GHz MaxDeltaS=0.02 MaximumPasses=20 MinimumPasses=1 MinimumConvergedPasses=1 PercentRefinement=30 BasisOrder=1 PortAccuracy=2 DrivenSolverType="Direct Solver"
    sweep Sweep: 70GHz to 110GHz, 401 points; Type=Interpolating SaveFields InterpTolerance=0.5 InterpMaxSolns=250 InterpUsePortImped=false PassivityErrorTolerance=0.0001
source amplitudes:
  C:1: 1W 0deg
  C:2..C:5, R:1..R:5: 0W 0deg
reports:
  S Parameter Plot 1: dB(S(C:1,C:1)), dB(S(C:2,C:2)), dB(S(C:3,C:3)), dB(S(C:4,C:4)), dB(S(C:5,C:5)), dB(S(R:1,R:1)), dB(S(R:2,R:2)), dB(S(R:3,R:3)), dB(S(R:4,R:4)), dB(S(R:5,R:5)) vs Freq on Setup1 : Sweep
  S Parameter Plot 2: dB(S(C:2,C:1)), dB(S(C:3,C:1)), dB(S(C:4,C:1)), dB(S(C:5,C:1)), dB(S(R:1,C:1)), dB(S(R:2,C:1)), dB(S(R:3,C:1)), dB(S(R:4,C:1)), dB(S(R:5,C:1)), dB(S(C:1,C:2)), dB(S(C:3,C:2)), dB(S(C:4,C:2)), dB(S(C:5,C:2)), dB(S(R:1,C:2)), dB(S(R:2,C:2)), dB(S(R:3,C:2)), dB(S(R:4,C:2)), dB(S(R:5,C:2)), dB(S(C:1,C:3)), dB(S(C:2,C:3)), dB(S(C:4,C:3)), dB(S(C:5,C:3)), dB(S(R:1,C:3)), dB(S(R:2,C:3)), dB(S(R:3,C:3)), dB(S(R:4,C:3)), dB(S(R:5,C:3)), dB(S(C:1,C:4)), dB(S(C:2,C:4)), dB(S(C:3,C:4)), dB(S(C:5,C:4)), dB(S(R:1,C:4)), dB(S(R:2,C:4)), dB(S(R:3,C:4)), dB(S(R:4,C:4)), dB(S(R:5,C:4)), dB(S(C:1,C:5)), dB(S(C:2,C:5)), dB(S(C:3,C:5)), dB(S(C:4,C:5))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 vs Freq on Setup1 : Sweep
  S Parameter Plot 3: dB(S(R:1,C:1)), dB(S(C:1,C:1)), dB(S(R:1,R:1)), dB(S(R:1,C:2)) vs Freq on Setup1 : Sweep
